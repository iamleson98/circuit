* Standard vendor SPICE models (ON Semi / Fairchild 2N3904 & 2N2222A; NXP BC547B)
.model Q2N3904 NPN(IS=6.734f BF=416.4 NE=1.259 ISE=6.734f IKF=66.78m BR=.7371 NC=2 RC=1 RB=10 VAF=74.03 CJC=3.638p MJC=.3085 VJC=.75 FC=.5 CJE=4.493p MJE=.2593 VJE=.75 TR=239.5n TF=301.2p)
.model Q2N2222A NPN(IS=14.34f BF=255.9 NE=1.307 ISE=14.34f IKF=.2847 BR=6.092 NC=2 RC=1 RB=10 VAF=74.03 CJC=7.306p MJC=.3416 VJC=.75 FC=.5 CJE=22.01p MJE=.377 VJE=.75 TR=46.91n TF=411.1p)
.model BC547B NPN(IS=2.39E-14 NF=1.008 ISE=3.545E-15 NE=1.541 BF=294.3 IKF=0.1357 VAF=63.2 NR=1.004 ISC=6.272E-14 NC=1.243 BR=7.946 IKR=0.1144 VAR=25.9 RB=1 RE=0.4683 RC=0.85 CJE=1.358E-11 VJE=0.65 MJE=0.3279 TF=4.391E-10 CJC=3.728E-12 VJC=0.3997 MJC=0.2955 TR=1E-9 FC=0.9579)
.model D1N34A D(IS=1.3e-7 N=1.3 RS=7 CJO=0.6p VJ=0.3 M=0.4 TT=2n)
.model D1N4148 D(IS=2.52n N=1.752 RS=0.568 CJO=4p M=0.4 VJ=0.75 TT=20n)
.model LEDG D(IS=4.7e-20 N=2 RS=5 CJO=20p)

* LED models fitted to 5 mm parts (V = N·Vt·ln(I/IS) + I·RS):
.model LEDB D(IS=3.981e-21 N=2.6 RS=15 CJO=30p)
.model LEDW D(IS=3.981e-21 N=2.6 RS=15 CJO=30p)
.model LEDY D(IS=1.647e-18 N=2.0 RS=10 CJO=30p)
.model D1N5819 D(IS=31.7u N=1.373 RS=0.051 CJO=110p M=0.35)* Tricolor lamp controller — generated from the routed board by harness/tools/board_to_spice.mjs
* J1: the 12 V wall supply (its output stage and caps live here too):
VPSU psu_emf 0 12
SWALL psu_emf psu_out RON=0.05 ROFF=1e9  ; switched on at t = 0
CPSU psu_out 0 1000u
RJ1 psu_out n_f1_a 0.005
RJ1G 0 0 0.001
RF1 n_f1_a n_d1_pin1 0.15  ; MF-R110 polyfuse, cold
D1 n_d1_pin1 v12 D1N5819
C1 v12 0 0.00047
C2 v12 0 1e-7
* U1: 78L05 — pass transistor, base clamped at 5.6 V and ≥ 1.2 V below IN
DU1A v12 u1_d D1N4148
DU1B u1_d u1_e D1N4148
RU1B u1_e u1_b 2k
DU1Z u1_b u1_ref D1N4148
VU1REF u1_ref 0 5.0
QU1 v12 u1_b vreg Q2N2222A
RU1Q v12 0 3.9k  ; ≈ 3 mA quiescent
C3 v12 0 3.3e-7
C4 vreg 0 1e-7
D2 vreg vcc D1N4148
C5 vcc 0 0.00022
* U2: ATtiny85 — supply current and three output pins; PB4 carries the PWM
RU2SLEEP vcc 0 360e3  ; asleep
SU2AWAKE vcc u2_a RON=1 ROFF=1e12
RU2A u2_a 0 5.5k  ; + 0.8 mA awake
EPB0 u2_pb0 0 vcc 0 0
RPB0 u2_pb0 g1 50
EPB1 u2_pb1 0 vcc 0 0
RPB1 u2_pb1 g2 50
EPB4 u2_pb4 0 vcc 0 0
RPB4 u2_pb4 g3 50
C6 vcc 0 1e-7
R1 vcc rst 10000
R2 v12 sense 100000
R3 sense 0 33000
C7 sense 0 1e-8
* J2: ISP header, nothing plugged in
* J3: no jumper (the MODE pot's wiper sets it)
R6 mode n_j3_mid 10000
R4 vcc mode 1000000
R5 mode 0 1000000
C8 mode 0 1e-8
SQ1 blue_n 0 RON=0.025 ROFF=1e8  ; IRLZ44N
CQ1G gate1 0 1.8n
SQ2 white_n 0 RON=0.025 ROFF=1e8  ; IRLZ44N
CQ2G gate2 0 1.8n
SQ3 yellow_n 0 RON=0.025 ROFF=1e8  ; IRLZ44N
CQ3G gate3 0 1.8n
R7 g1 gate1 100
R8 g2 gate2 100
R9 g3 gate3 100
R10 gate1 0 100000
R11 gate2 0 100000
R12 gate3 0 100000
* J4: the four-wire cable to the LED panel (nets shared below)
* Tricolor lamp LED panel — generated from the routed board by harness/tools/board_to_spice.mjs
RP_1 v12 P_n_d1a_pin1 150
DP_D1a P_n_d1a_pin1 P_n_d1a_pin2 LEDB
DP_D1b P_n_d1a_pin2 P_n_d1b_pin2 LEDB
DP_D1c P_n_d1b_pin2 blue_n LEDB
RP_2 v12 P_n_d2a_pin1 150
DP_D2a P_n_d2a_pin1 P_n_d2a_pin2 LEDW
DP_D2b P_n_d2a_pin2 P_n_d2b_pin2 LEDW
DP_D2c P_n_d2b_pin2 white_n LEDW
RP_3 v12 P_n_d3a_pin1 220
DP_D3a P_n_d3a_pin1 P_n_d3a_pin2 LEDY
DP_D3b P_n_d3a_pin2 P_n_d3b_pin2 LEDY
DP_D3c P_n_d3b_pin2 P_n_d3c_pin2 LEDY
DP_D3d P_n_d3c_pin2 yellow_n LEDY
RP_4 v12 P_n_d4a_pin1 150
DP_D4a P_n_d4a_pin1 P_n_d4a_pin2 LEDW
DP_D4b P_n_d4a_pin2 P_n_d4b_pin2 LEDW
DP_D4c P_n_d4b_pin2 white_n LEDW
RP_5 v12 P_n_d5a_pin1 220
DP_D5a P_n_d5a_pin1 P_n_d5a_pin2 LEDY
DP_D5b P_n_d5a_pin2 P_n_d5b_pin2 LEDY
DP_D5c P_n_d5b_pin2 P_n_d5c_pin2 LEDY
DP_D5d P_n_d5c_pin2 yellow_n LEDY
RP_6 v12 P_n_d6a_pin1 150
DP_D6a P_n_d6a_pin1 P_n_d6a_pin2 LEDB
DP_D6b P_n_d6a_pin2 P_n_d6b_pin2 LEDB
DP_D6c P_n_d6b_pin2 blue_n LEDB
RP_7 v12 P_n_d7a_pin1 220
DP_D7a P_n_d7a_pin1 P_n_d7a_pin2 LEDY
DP_D7b P_n_d7a_pin2 P_n_d7b_pin2 LEDY
DP_D7c P_n_d7b_pin2 P_n_d7c_pin2 LEDY
DP_D7d P_n_d7c_pin2 yellow_n LEDY
RP_8 v12 P_n_d8a_pin1 150
DP_D8a P_n_d8a_pin1 P_n_d8a_pin2 LEDB
DP_D8b P_n_d8a_pin2 P_n_d8b_pin2 LEDB
DP_D8c P_n_d8b_pin2 blue_n LEDB
RP_9 v12 P_n_d9a_pin1 150
DP_D9a P_n_d9a_pin1 P_n_d9a_pin2 LEDW
DP_D9b P_n_d9a_pin2 P_n_d9b_pin2 LEDW
DP_D9c P_n_d9b_pin2 white_n LEDW
RP_10 v12 P_n_d10a_pin1 150
DP_D10a P_n_d10a_pin1 P_n_d10a_pin2 LEDB
DP_D10b P_n_d10a_pin2 P_n_d10b_pin2 LEDB
DP_D10c P_n_d10b_pin2 blue_n LEDB
RP_11 v12 P_n_d11a_pin1 150
DP_D11a P_n_d11a_pin1 P_n_d11a_pin2 LEDW
DP_D11b P_n_d11a_pin2 P_n_d11b_pin2 LEDW
DP_D11c P_n_d11b_pin2 white_n LEDW
RP_12 v12 P_n_d12a_pin1 220
DP_D12a P_n_d12a_pin1 P_n_d12a_pin2 LEDY
DP_D12b P_n_d12a_pin2 P_n_d12b_pin2 LEDY
DP_D12c P_n_d12b_pin2 P_n_d12c_pin2 LEDY
DP_D12d P_n_d12c_pin2 yellow_n LEDY
RP_13 v12 P_n_d13a_pin1 150
DP_D13a P_n_d13a_pin1 P_n_d13a_pin2 LEDW
DP_D13b P_n_d13a_pin2 P_n_d13b_pin2 LEDW
DP_D13c P_n_d13b_pin2 white_n LEDW
RP_14 v12 P_n_d14a_pin1 220
DP_D14a P_n_d14a_pin1 P_n_d14a_pin2 LEDY
DP_D14b P_n_d14a_pin2 P_n_d14b_pin2 LEDY
DP_D14c P_n_d14b_pin2 P_n_d14c_pin2 LEDY
DP_D14d P_n_d14c_pin2 yellow_n LEDY
RP_15 v12 P_n_d15a_pin1 150
DP_D15a P_n_d15a_pin1 P_n_d15a_pin2 LEDB
DP_D15b P_n_d15a_pin2 P_n_d15b_pin2 LEDB
DP_D15c P_n_d15b_pin2 blue_n LEDB
RP_16 v12 P_n_d16a_pin1 220
DP_D16a P_n_d16a_pin1 P_n_d16a_pin2 LEDY
DP_D16b P_n_d16a_pin2 P_n_d16b_pin2 LEDY
DP_D16c P_n_d16b_pin2 P_n_d16c_pin2 LEDY
DP_D16d P_n_d16c_pin2 yellow_n LEDY
RP_17 v12 P_n_d17a_pin1 150
DP_D17a P_n_d17a_pin1 P_n_d17a_pin2 LEDB
DP_D17b P_n_d17a_pin2 P_n_d17b_pin2 LEDB
DP_D17c P_n_d17b_pin2 blue_n LEDB
RP_18 v12 P_n_d18a_pin1 150
DP_D18a P_n_d18a_pin1 P_n_d18a_pin2 LEDW
DP_D18b P_n_d18a_pin2 P_n_d18b_pin2 LEDW
DP_D18c P_n_d18b_pin2 white_n LEDW
* J1: the cable (V12/GND/×_N shared with the controller)
.tran 50n 3m
.end
